* inverter
* Parameters:
*   tplv = PMOS transistor length variation
*   tpwv = PMOS transistor width variation
*   tnlv = NMOS transistor length variation
*   tnwv = NMOS transistor wideth variation
*   tpotv = PMOS trnasistor oxide layer thickness variation
*   tnotv = NMOS transistor oxide layer thickness variation

.subckt inverter in out
+ params: tplv=1 tpwv=1 tnlv=1 tnwv=1 tpotv=1 tnotv=1

M0 out in vdd vdd tp L={65n * tplv} W={216n * tpwv}
+ AS=75.3f AD=75.3f PS=1.23u PD=1.23u
M1 out in vss vss tn L={65n * tnlv} W={130n * tnwv}
+ AS=75.3f AD=75.3f PS=1.12u PD=1.23u

*BSIM 4.8.3 models
.model tp pmos level=54 version=4.8.3 TOX={1.95n * tpotv}
.model tn nmos level=54 version=4.8.3 TOX={130n * tnotv}
.ends inverter
