* ring oscillator 4
.subckt ring_oscillator_4 in n12
xNAND in n12 n0 nand2x1
x1 n0 n1 inverter tplv=0.9480785514117377 tpwv=0.9524902616961389 tnlv=0.9921741664834003 tnwv=1.030310967086803 tpotv=1.0551627439876259 tnotv=0.9787622915815991
x2 n1 n2 inverter tplv=1.0628199014314628 tpwv=0.8987879915184889 tnlv=0.9621646386626695 tnwv=0.9172050245731926 tpotv=0.9704854745679364 tnotv=1.023495556590031
x3 n2 n3 inverter tplv=0.9178425103466463 tpwv=1.0033453078535184 tnlv=0.9432074678248086 tnwv=1.0016527718032733 tpotv=1.0015971507708814 tnotv=0.970012040091343
x4 n3 n4 inverter tplv=0.9538124396823638 tpwv=0.9880381829628492 tnlv=0.9400531274738466 tnwv=1.0220530919630382 tpotv=1.0410013722211324 tnotv=1.01640851180807
x5 n4 n5 inverter tplv=0.9768379281373177 tpwv=1.0515305792265646 tnlv=1.0628176931799076 tnwv=0.9773284191357056 tpotv=0.9861585876023498 tnotv=1.0935851591825139
x6 n5 n6 inverter tplv=0.9608578674199832 tpwv=0.9311447146450854 tnlv=0.9630491344472988 tnwv=1.0200292122843444 tpotv=0.9519724994297712 tnotv=0.9722616580887227
x7 n6 n7 inverter tplv=1.1199217681147726 tpwv=1.0174733483428742 tnlv=1.0034618428939455 tnwv=0.9634286558132779 tpotv=0.9667852822938371 tnotv=1.0684639499505821
x8 n7 n8 inverter tplv=1.0478590799633671 tpwv=0.9708817639475987 tnlv=0.9981626994285917 tnwv=1.0285414706334663 tpotv=0.9155485177239693 tnotv=1.0160691552517365
x9 n8 n9 inverter tplv=1.0192639163060115 tpwv=0.9641289050916411 tnlv=1.0291751057606662 tnwv=1.0813744077707814 tpotv=0.9367961179077819 tnotv=1.0405604183008457
x10 n9 n10 inverter tplv=1.0495242717078357 tpwv=0.9527888029649968 tnlv=0.9435310601678787 tnwv=0.9271972315626205 tpotv=1.0588884282705229 tnotv=0.924149323072972
x11 n10 n11 inverter tplv=1.0286691289016727 tpwv=1.0478363403368274 tnlv=0.9782556639855241 tnwv=0.9897547059976526 tpotv=0.949180599992359 tnotv=1.031198164258489
x12 n11 n12 inverter tplv=0.9928209288453509 tpwv=0.8840003865441615 tnlv=1.0072822277886708 tnwv=0.9867082357213136 tpotv=1.0633043946323115 tnotv=0.9488685455448076

.ends ring oscillator
