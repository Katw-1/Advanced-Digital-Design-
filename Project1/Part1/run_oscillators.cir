* run_oscillators

.include inverter.cir
.include nand.cir
.include ring_oscillator_0.cir
.include ring_oscillator_1.cir
.include ring_oscillator_2.cir
.include ring_oscillator_3.cir
.include ring_oscillator_4.cir
.include ring_oscillator_5.cir
.include ring_oscillator_6.cir
.include ring_oscillator_7.cir

.global vdd
.global vss

Vdd vdd 0 dc 1.2v
Vss vss 0 dc 0v

x0 in osc0 ring_oscillator_0
x1 in osc1 ring_oscillator_1
x2 in osc2 ring_oscillator_2
x3 in osc3 ring_oscillator_3
x4 in osc4 ring_oscillator_4
x5 in osc5 ring_oscillator_5
x6 in osc6 ring_oscillator_6
x7 in osc7 ring_oscillator_7

Vin in vss pwl(0n 0V 4n 0V 5n 1.2V 100n 1.2V)

.control
tran 0.01n 100n 0n

plot in osc0 osc1 osc2 osc3 osc4 osc5 osc6 osc7

plot in
+ osc0 osc1 osc2 osc3 osc4 osc5 osc6 osc7
+ xlimit 90n 100n
.endc
.end
